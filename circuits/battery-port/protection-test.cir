Helios physical protection architecture, low-voltage operating sequence
.include protection.lib
Vp pok 0 PWL(0 0 0.2u 0 0.21u 3.3)
Vs sok 0 PWL(0 0 0.4u 0 0.41u 3.3 25u 3.3 25.01u 0 26u 0 26.01u 3.3)
Vi cur 0 PWL(0 0 3u 0 3.1u 2.4 4u 2.4 4.1u -2.4 5u -2.4 5.1u 0
+ 6u 0 6.1u 5.4 8u 5.4 8.1u 0 14u 0 14.1u -5.4 16u -5.4 16.1u 0)
Varm arm 0 PWL(0 0 1u 0 1.01u 3.3 1.3u 3.3 1.31u 0
+ 6.8u 0 6.81u 3.3 9u 3.3 9.01u 0 10u 0 10.01u 3.3 10.3u 3.3 10.31u 0
+ 12u 0 12.01u 3.3 12.3u 3.3 12.31u 0
+ 15u 0 15.01u 3.3 17.5u 3.3 17.51u 0 20u 0 20.01u 3.3 20.3u 3.3 20.31u 0)
Vrun run 0 PWL(0 0 2u 0 2.01u 3.3 6.5u 3.3 6.51u 0 8.5u 0 8.51u 3.3
+ 11u 3.3 11.01u 0 13u 0 13.01u 3.3 14.6u 3.3 14.61u 0
+ 16.6u 0 16.61u 3.3 19u 3.3 19.01u 0 21u 0 21.01u 3.3)
Xflt cur pok sok arm run enp ens sense BENCH_PROTECT
Bany any_en 0 V={max(v(enp),v(ens))}
Bboth both_en 0 V={min(v(enp),v(ens))}
.tran 2n 29u
.meas tran startup MAX v(any_en) from=0.45u to=0.99u
.meas tran ordinary MIN v(both_en) from=2.2u to=5.9u
.meas tran pos_before_arm MAX v(any_en) from=6.3u to=6.45u
.meas tran pos_held_arm MAX v(any_en) from=8.6u to=8.95u
.meas tran run_arm_block MAX v(any_en) from=10.1u to=10.9u
.meas tran fresh_arm MIN v(both_en) from=13.2u to=13.9u
.meas tran neg_before_arm MAX v(any_en) from=14.3u to=14.55u
.meas tran neg_held_arm MAX v(any_en) from=16.8u to=18.9u
.meas tran next_arm MIN v(both_en) from=21.2u to=24.9u
.meas tran lost_bias MAX v(any_en) from=25.3u to=28.9u
.meas tran pos_dt TRIG v(sense) VAL=2.054 RISE=1 TARG v(ens) VAL=1.65 FALL=1 TD=6u
.meas tran neg_dt TRIG v(sense) VAL=1.246 FALL=1 TARG v(ens) VAL=1.65 FALL=1 TD=14u
.end
